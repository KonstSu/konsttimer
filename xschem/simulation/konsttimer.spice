** sch_path: /home/ttuser/asic/konsttimer/xschem/konsttimer.sch
.subckt konsttimer VDD NRESET THRES OUT VCTRL TRIG DISCH VSS
*.PININFO VDD:B VSS:B DISCH:B VCTRL:B THRES:B TRIG:B NRESET:B OUT:B
XM2 net4 net4 VSS VSS sky130_fd_pr__nfet_01v8 L=2 W=20 nf=1 m=1
XM1 net1 net4 VSS VSS sky130_fd_pr__nfet_01v8 L=2 W=20 nf=1 m=1
XM3 net2 THRES net1 VSS sky130_fd_pr__nfet_01v8 L=2 W=20 nf=1 m=1
XM4 net3 VCTRL net1 VSS sky130_fd_pr__nfet_01v8 L=2 W=20 nf=1 m=1
XM5 net2 net3 VDD VDD sky130_fd_pr__pfet_01v8 L=2 W=20 nf=1 m=1
XM6 net3 net3 VDD VDD sky130_fd_pr__pfet_01v8 L=2 W=20 nf=1 m=1
XM7 net5 net5 VDD VDD sky130_fd_pr__pfet_01v8 L=2 W=20 nf=1 m=1
XM8 net7 net7 VSS VSS sky130_fd_pr__nfet_01v8 L=2 W=20 nf=1 m=1
XM9 net8 net7 VSS VSS sky130_fd_pr__nfet_01v8 L=2 W=20 nf=1 m=1
XM10 net7 net6 net9 net9 sky130_fd_pr__pfet_01v8 L=2 W=20 nf=1 m=1
XM11 net8 TRIG net9 net9 sky130_fd_pr__pfet_01v8 L=2 W=20 nf=1 m=1
XM12 net9 net5 VDD VDD sky130_fd_pr__pfet_01v8 L=2 W=20 nf=1 m=1
XM13 net10 net2 VDD VDD sky130_fd_pr__pfet_01v8 L=2 W=20 nf=1 m=1
XM14 net8 NRESET VDD VDD sky130_fd_pr__pfet_01v8 L=2 W=20 nf=1 m=1
XM15 net11 net5 VDD VDD sky130_fd_pr__pfet_01v8 L=2 W=20 nf=1 m=1
XM16 net12 net5 VDD VDD sky130_fd_pr__pfet_01v8 L=2 W=20 nf=1 m=1
XM17 net10 net4 VSS VSS sky130_fd_pr__nfet_01v8 L=2 W=20 nf=1 m=1
XM18 net12 net10 VSS VSS sky130_fd_pr__nfet_01v8 L=2 W=20 nf=1 m=1
XM19 net11 net8 VSS VSS sky130_fd_pr__nfet_01v8 L=2 W=20 nf=1 m=1
XM20 net11 net12 VSS VSS sky130_fd_pr__nfet_01v8 L=2 W=20 nf=1 m=1
XM21 net12 net11 VSS VSS sky130_fd_pr__nfet_01v8 L=2 W=20 nf=1 m=1
XM22 net13 net12 VSS VSS sky130_fd_pr__nfet_01v8 L=2 W=20 nf=1 m=1
XM23 net13 net12 VDD VDD sky130_fd_pr__pfet_01v8 L=2 W=20 nf=1 m=1
XM24 OUT net13 VSS VSS sky130_fd_pr__nfet_01v8 L=2 W=20 nf=1 m=1
XM25 OUT net13 VDD VDD sky130_fd_pr__pfet_01v8 L=2 W=20 nf=1 m=1
XM26 DISCH net13 VSS VSS sky130_fd_pr__nfet_01v8 L=2 W=20 nf=1 m=10
XR14 net4 net5 VSS sky130_fd_pr__res_high_po_2p85 L=2.85 mult=1 m=1
XR2 net6 VCTRL VSS sky130_fd_pr__res_high_po_2p85 L=2.85 mult=1 m=1
XR1 VCTRL VDD VSS sky130_fd_pr__res_high_po_2p85 L=2.85 mult=1 m=1
XR3 VSS net6 VSS sky130_fd_pr__res_high_po_2p85 L=2.85 mult=1 m=1
.ends
.end
